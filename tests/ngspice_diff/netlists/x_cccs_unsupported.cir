CCCS (F source), expected ENGINE-UNSUPPORTED
V1 1 0 DC 1
R1 1 2 1k
Vs 2 0 0
F1 0 3 Vs 2
R2 3 0 1k
.op
.end
