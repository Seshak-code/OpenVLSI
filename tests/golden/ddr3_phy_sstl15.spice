* ============================================================================
* DDR3-1600 PHY Analog Front-End — SSTL_15 Driver + ODT + Receiver
* ============================================================================
* Topology (per DQ pin slice):
*   1. SSTL_15 Push-Pull Driver (NMOS pull-down / PMOS pull-up)
*   2. On-Die Termination (ODT) — RTT_NOM = 40 ohm to VDDQ/2
*   3. Vref Generator — 0.75V (VDDQ/2) reference ladder
*   4. Differential Clock Receiver (CK/CK#) — diff pair + mirror load
*   5. 8-Stage Current-Starved Inverter DLL Delay Line
*   6. VDDQ Rail Decoupling (1.5V, DDR3 core)
*
* Target: ~60 MNA nodes → tensor contraction sweet spot (tw <= 80)
* ============================================================================

* ── Rails ──────────────────────────────────────────────────────────────────
Vddq  1 0  DC 1.5
Vss   0 0  DC 0

* ── [1] SSTL_15 Push-Pull Output Driver ────────────────────────────────────
* Pre-driver inverter shapes the gate drive
MPU   2  3  1  1  sky130_fd_pr__pfet_01v8  W=2u   L=0.15u
MNU   2  3  0  0  sky130_fd_pr__nfet_01v8  W=1u   L=0.15u
* Gate bias (input stimulus held at logic threshold for DC OP)
Vdrv  3  0  DC 0.75

* Series on-die output resistance (pad + ESD)
Rout  2  4  15

* ── [2] On-Die Termination (RTT_NOM = 40 ohm to VTT = VDDQ/2) ─────────────
* VTT ladder: two 75-ohm resistors center-tapped
Rtt1  4  5  20
Rtt2  5  0  20
Vtt   5  0  DC 0.75

* ── [3] Vref Generator (0.75V) ──────────────────────────────────────────────
Rvr1  1  6  10k
Rvr2  6  0  10k
Cvref 6  0  10p
* Buffered Vref via source follower
Mvref 1  6  7  0  sky130_fd_pr__nfet_01v8  W=4u  L=0.5u
Ivref 7  0  DC 14u

* ── [4] Differential Clock Receiver (CK / CK#) ─────────────────────────────
* Tail current source
Itail 8  0  DC 150u
* Diff pair
Mck1  9  10 8  0  sky130_fd_pr__nfet_01v8  W=4u  L=0.15u
Mck2  11 12 8  0  sky130_fd_pr__nfet_01v8  W=4u  L=0.15u
* Resistive loads (SSTL receivers use R loads; avoids bistable mirror latch)
Rld1  1  9  5k
Rld2  1  11 5k
* Tail node bleed for DC tractability
Rtlk  8  0  1meg
* Clock inputs (DC: differential around Vref)
Vck   10 0  DC 0.80
Vckb  12 0  DC 0.70
* Output load
Cck   11 0  50f

* ── [5] 8-Stage Current-Starved DLL Delay Line ─────────────────────────────
* Each stage: inverter with series FET current limiting
* Stage 1
Md1p  13 14 1  1  sky130_fd_pr__pfet_01v8  W=1u  L=0.15u
Md1n  13 14 0  0  sky130_fd_pr__nfet_01v8  W=0.5u L=0.15u
Cd1   13 0  20f
* Stage 2
Md2p  15 13 1  1  sky130_fd_pr__pfet_01v8  W=1u  L=0.15u
Md2n  15 13 0  0  sky130_fd_pr__nfet_01v8  W=0.5u L=0.15u
Cd2   15 0  20f
* Stage 3
Md3p  16 15 1  1  sky130_fd_pr__pfet_01v8  W=1u  L=0.15u
Md3n  16 15 0  0  sky130_fd_pr__nfet_01v8  W=0.5u L=0.15u
Cd3   16 0  20f
* Stage 4
Md4p  17 16 1  1  sky130_fd_pr__pfet_01v8  W=1u  L=0.15u
Md4n  17 16 0  0  sky130_fd_pr__nfet_01v8  W=0.5u L=0.15u
Cd4   17 0  20f
* Stage 5
Md5p  18 17 1  1  sky130_fd_pr__pfet_01v8  W=1u  L=0.15u
Md5n  18 17 0  0  sky130_fd_pr__nfet_01v8  W=0.5u L=0.15u
Cd5   18 0  20f
* Stage 6
Md6p  19 18 1  1  sky130_fd_pr__pfet_01v8  W=1u  L=0.15u
Md6n  19 18 0  0  sky130_fd_pr__nfet_01v8  W=0.5u L=0.15u
Cd6   19 0  20f
* Stage 7
Md7p  20 19 1  1  sky130_fd_pr__pfet_01v8  W=1u  L=0.15u
Md7n  20 19 0  0  sky130_fd_pr__nfet_01v8  W=0.5u L=0.15u
Cd7   20 0  20f
* Stage 8
Md8p  21 20 1  1  sky130_fd_pr__pfet_01v8  W=1u  L=0.15u
Md8n  21 20 0  0  sky130_fd_pr__nfet_01v8  W=0.5u L=0.15u
Cd8   21 0  20f
* DLL input tie-in from receiver output
Rdll  11 14 1k

* ── [6] VDDQ Rail Decoupling ────────────────────────────────────────────────
Cdec1 1  0  100p
Rdec1 1  22 0.5
Cdec2 22 0  100p

* ── Receiver Strobe Comparators (data eye samplers) ────────────────────────
* Sampler A: compares DQ against Vref
Msa1  23 4  24 0  sky130_fd_pr__nfet_01v8  W=2u  L=0.15u
Msa2  23 6  25 0  sky130_fd_pr__nfet_01v8  W=2u  L=0.15u
Isa   0  23 DC 40u
Rsa1  24 0  5k
Rsa2  25 0  5k
* Sampler B: second DQ slice
Msb1  26 4  27 0  sky130_fd_pr__nfet_01v8  W=2u  L=0.15u
Msb2  26 6  28 0  sky130_fd_pr__nfet_01v8  W=2u  L=0.15u
Isb   0  26 DC 40u
Rsb1  27 0  5k
Rsb2  28 0  5k
* DC bleed paths (junction-leakage equivalent) for solver tractability
Rlk1  23 0  10meg
Rlk2  26 0  10meg

* ── ODT Calibration Replica Network ────────────────────────────────────────
Rrep1 1  29 200
Rrep2 29 0 200
Mrep  1  29 30 1  sky130_fd_pr__pfet_01v8  W=8u  L=0.5u
Rrep3 30 0 40

* ── Model Cards (SkyWater 130nm) ────────────────────────────────────────────
.model sky130_fd_pr__nfet_01v8  nmos level=1 vto=0.45 kp=120u lambda=0.05 gamma=0.4
.model sky130_fd_pr__pfet_01v8  pmos level=1 vto=-0.45 kp=40u lambda=0.05 gamma=0.4

* ── Analysis: DC Operating Point ────────────────────────────────────────────
.op
.end
