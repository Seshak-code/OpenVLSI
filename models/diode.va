// Shockley Diode Model - Verilog-A Subset
// Test file for the Physics Compiler Verilog-A Frontend

`include "disciplines.vams"

module diode_va(a, c);
    inout a, c;
    electrical a, c;

    parameter real Is  = 1.0e-14;   // Saturation current [A]
    parameter real N   = 1.0;       // Emission coefficient
    parameter real Rs  = 0.0;       // Series resistance [Ohm]
    parameter real GMIN = 1.0e-12;  // Minimum conductance [S]

    real Vd, Id, Gd, Vt, arg, exp_val;

    analog begin
        Vt = 0.02585;
        Vd = V(a, c);
        arg = Vd / (N * Vt);

        // Clamp argument to prevent overflow
        if (arg > 30.0)
            arg = 30.0;

        exp_val = exp(arg);
        Id = Is * (exp_val - 1.0);
        Gd = Is / (N * Vt) * exp_val;

        // Branch current contribution
        I(a, c) <+ Id;
    end
endmodule
